* x0xb0x mainboard netlist
CC10 N_108 N_110 .01
CC100 0 TEMPO_SW_A .001
CC101 0 TEMPO_SW_B .001
CC102 V5 0 100/10
CC103 V5 0 .1
CC104 0 V5 .1
CC105 N_90 0 1/50
CC106 0 V5 .1
CC107 0 V5 .1
CC108 0 V5 .1
CC109 0 V5 .1
CC11 N_302 0 1/50
CC110 0 V5 .1
CC111 0 V5 .1
CC112 0 V5 .1
CC113 0 V5 .1
CC13 N_161 0 1/50
CC14 N_144 N_27 1/50
CC15 N_133 N_26 1/50
CC16 N_125 0 10/16
CC17 N_123 N_124 1/50
CC18 N_121 N_118 .018
CC19 N_117 Q17 .033
CC20 N_21 N_26 .01
CC21 N_25 N_27 .01
CC22 N_132 0 1/50
CC23 N_128 N_130 1/50
CC24 N_116 N_119 .033
CC25 N_143 N_138 .1
CC26 N_143 N_120 .033
CC27 N_120 N_141 .1
CC28 N_122 0 47/16
CC29 N_582 0 1/50
CC30 N_115 0 10/16
CC31 V533 0 10/16
CC32 V12 0 10/16
CC33 N_113 0 .01
CC34 N_97 N_98 .001
CC35 N_82 0 .22
CC36 N_34 0 .033
CC37 N_22 0 10/16
CC38 N_48 N_32 1/50
CC40 N_31 0 10/16
CC41 N_65 0 .1
CC42 N_68 0 1/35
CC43 N_11 N_10 1000/6.3
CC44 N_13 N_11 47/16
CC45 N_11 0 .068
CC46 _6V N_13 .01
CC47 N_8 N_9 .0068
CC48 C48 0 100/6.3
CC49 _6V 0 100/6.3
CC50 N_3 N_4 10/16
CC51 N_2 N_1 2.2/50
CC52 N_17 0 10/16
CC53 N_16 0 47/16
CC54 N_42 N_43 .047
CC55 N_36 0 47/16
CC56 N_6 N_7 1/50
CC58 N_19 N_20 1/50
CC59 N_18 N_158 1/50
CC62 N_46 0 1/35
CC72 V12 N_37 10/16
DD1 N_90 V5 DMOD
DD10 ROTARY8 N_301 DMOD
DD2 N_294 N_90 DMOD
DD24 N_35 N_159 DMOD
DD25 N_103 N_104 DMOD
DD26 N_50 0 DMOD
DD27 N_33 N_69 DMOD
DD28 N_52 N_51 DMOD
DD29 N_51 N_50 DMOD
DD3 ROTARY1 N_168 DMOD
DD30 0 N_625 DMOD
DD31 N_625 V12 DMOD
DD32 0 N_11 DMOD
DD33 N_11 _6V DMOD
DD34 N_39 N_58 DMOD
DD35 N_39 N_63 DMOD
DD36 N_45 N_64 DMOD
DD37 N_45 N_41 DMOD
DD4 ROTARY2 N_175 DMOD
DD5 ROTARY4 N_295 DMOD
DD6 ROTARY8 N_297 DMOD
DD7 ROTARY1 N_298 DMOD
DD8 ROTARY2 N_299 DMOD
DD9 ROTARY4 N_300 DMOD
QQ1 N_29 N_621 V12 PNP2SA
QQ10 N_561 N_134 N_147 PNP2SA
QQ11 N_146 N_147 N_561 NPN2SC
QQ12 N_118 N_124 N_127 NPN2SC
QQ12b N_121 N_60 N_127 NPN2SC
QQ13 N_117 N_117 N_118 NPN2SC
QQ14 N_116 N_116 N_117 NPN2SC
QQ15 Q17 Q17 N_121 NPN2SC
QQ16 N_143 N_143 N_116 NPN2SC
QQ17 N_119 N_119 Q17 NPN2SC
QQ18 N_122 N_131 N_130 NPN2SC
QQ19 N_122 N_140 N_144 NPN2SC
QQ2 N_621 N_621 V12 PNP2SA
QQ20 N_139 N_135 N_136 NPN2SC
QQ21 N_140 N_138 N_139 NPN2SC
QQ21b N_148 N_141 N_139 NPN2SC
QQ23 N_120 N_120 N_119 NPN2SC
QQ24 N_104 N_104 N_105 NPN2SC
QQ25 N_106 N_104 N_113 NPN2SC
QQ26 N_98 V533 N_101 NPN2SC
QQ26b N_113 N_99 N_101 NPN2SC
QQ27 N_103 N_106 V12 PNP2SA
JQ28 V12 N_113 N_108 J2SK30
QQ29 N_88 N_95 0 NPN2SC
QQ3 N_69 N_69 0 NPN2SC
QQ30 N_83 N_84 0 NPN2SC
QQ31 N_69 N_68 N_70 PNP2SA
QQ32 N_67 N_65 N_56 NPN2SC
QQ33 N_12 N_15 N_16 PNP2SA
QQ34 N_14 N_17 N_5 NPN2SC
QQ35 N_57 N_55 0 NPN2SC
QQ36 N_39 N_37 V12 PNP2SA
QQ37 N_43 N_44 0 NPN2SC
QQ38 N_45 N_40 N_36 PNP2SA
JQ39 N_53 0 0 J2SK30
QQ4 N_621 N_69 0 NPN2SC
QQ40 V12 N_46 N_47 NPN2SC
QQ41 V12 N_47 N_53 NPN2SC
QQ5 N_247 N_59 0 NPN2SC
QQ8 N_303 N_109 N_302 PNP2SA
QQ9 0 N_149 N_561 PNP2SA
RR100A N_99 V533 1k
RR100B V533 N_99 1k
RR101 N_105 V533 10k
RR102 N_98 N_114 100k
RR103 V12 N_98 220k
RR104 N_101 N_97 2.2k
RR105 0 N_108 10k
RR106 N_157 N_99 27k
RR107 N_85 N_625 2.2k
RR108 0 N_136 2.2k
RR109 N_135 0 10k
RR110 N_140 N_122 22k
RR111 N_122 N_148 22k
RR112 N_582 N_135 10k
RR113 N_141 N_582 100k
RR114 N_582 N_138 100k
RR115 N_122 N_115 10k
RR116 N_582 V533 10k
RR117 V533 N_50 22k
RR118 N_102 N_99 100k
RR119 N_34 N_35 47k
RR120 N_33 N_34 22k
RR121 N_25 N_623 220k
RR122 N_623 N_21 100k
RR123 N_68 V12 1.5MEG
RR124 N_623 N_22 2.2k
RR125 N_22 N_24 2.2k
RR126 V533 N_22 2.2k
RR127 N_28 N_30 47k
RR128 N_31 N_28 220k
RR129 N_30 N_31 22k
RR130 N_56 0 100
RR131 N_70 N_71 220k
RR132 N_68 N_67 100
RR133 N_71 N_63 2.2k
RR134 N_64 N_65 22k
RR135 0 N_4 4.7k
RR136 V12 N_16 100
RR137 N_58 N_622 1k
RR138 N_156 N_46 68k
RR139 N_57 V12 100k
RR140 N_55 0 100k
RR141 N_55 ACCENT 100k
RR142 N_37 V12 10k
RR143 N_43 N_37 10k
RR144 N_44 0 10k
RR145 0 N_39 10k
RR146 N_44 GATE 22k
RR148 N_42 N_40 10k
RR149 N_40 V12 10k
RR150 V12 N_36 22
RR151 0 N_45 22k
RR152 N_46 N_41 100
RR153 N_5 N_12 100k
RR154 N_14 N_16 100k
RR155 N_18 N_5 47k
RR156 N_5 N_19 100k
RR157 N_17 V533 10k
RR158 N_14 N_15 10k
RR159 N_2 N_12 33k
RR160 0 N_12 10k
RR161 N_6 N_12 1k
RR162 V533 N_31 2.2k
RR165 N_7 0 100k
RR200 V5 N_90 1MEG
RR201 N_233 0 10k
RR202 N_245 0 10k
RR203 N_210 N_279 10k
RR204 N_292 N_212 10k
RR205 N_211 N_291 10k
RR206 N_170 0 10k
RR207 0 N_107 10k
RR208 N_213 N_290 10k
RR209 N_176 0 10k
RR210 N_223 0 10k
RR211 N_214 N_289 10k
RR212 N_235 0 10k
RR213 N_215 N_288 10k
RR214 N_222 0 10k
RR215 N_216 N_287 10k
RR216 N_228 0 10k
RR217 N_286 N_217 10k
RR218 N_163 0 10k
RR219 N_227 0 10k
RR220 N_242 0 10k
RR221 N_199 N_285 10k
RR222 N_284 N_198 10k
RR223 N_196 N_283 10k
RR224 N_173 0 10k
RR225 N_165 0 10k
RR226 N_249 0 10k
RR227 N_209 N_282 10k
RR228 N_281 N_208 10k
RR229 N_204 N_280 10k
RR230 N_167 0 10k
RR231 N_244 0 10k
RR232 N_169 0 10k
RR233 TEMPO_SW 0 10k
RR234 N_177 N_187 10k
RR235 N_234 TEMPO_SW_A 220k
RR236 N_78 TEMPO_SW_B 220k
RR237 N_100 N_188 10k
RR238 N_270 N_202 10k
RR239 N_271 N_203 10k
RR240 N_229 0 10k
RR241 N_81 N_258 10k
RR242 N_184 N_259 10k
RR243 N_260 N_182 10k
RR244 N_129 N_183 10k
RR245 N_272 N_201 10k
RR246 N_200 N_273 10k
RR247 N_256 0 10k
RR248 N_218 N_274 10k
RR249 N_275 N_219 10k
RR250 N_137 N_185 10k
RR251 N_186 N_263 10k
RR252 N_238 N_23 10k
RR253 N_189 N_239 10k
RR254 N_59 ROTARYCOM3 10k
RR255 0 N_59 10k
RR256 N_190 N_240 10k
RR257 N_162 0 10k
RR258 N_220 N_276 10k
RR259 N_166 0 10k
RR260 N_207 N_241 10k
RR261 N_205 N_264 10k
RR262 N_191 N_206 10k
RR263 N_246 0 10k
RR264 N_192 N_278 10k
RR265 N_197 N_277 10k
RR266 N_261 N_195 10k
RR267 N_193 N_252 10k
RR268 N_194 N_269 10k
RR269 N_306 N_78 10k
RR270 N_234 N_306 10k
RR34 N_109 N_110 10k
RR35 N_108 N_109 100k
RR36 N_303 V533 10k
RR45 V12 N_302 22k
RR46 N_159 N_160 47k
RR47 N_142 N_561 10k
RR59 SLIDE N_95 100k
RR60 0 N_95 22k
RR61 N_49 N_561 10k
RR62 N_126 N_123 220k
RR63 N_134 N_153 220k
RR64 N_149 0 10k
RR65 N_149 V533 10k
RR66 N_132 V533 100k
RR67 N_133 N_131 2.2k
RR68 V533 N_125 2.2k
RR69 N_127 N_146 2.2k
RR70 N_124 N_125 2.2k
RR71 N_561 N_134 2.2k
RR72 N_134 N_152 100k
RR73 N_147 N_151 100k
RR74 N_243 N_237 200k
RR75 N_243 N_237 200k
RR76 N_243 N_155 200k
RR77 N_155 N_243 200k
RR78 V533 N_237 200k
RR79 N_89 N_93 200k
RR80 N_236 N_155 200k
RR81 N_243 N_91 200k
RR82 N_92 N_237 200k
RR83 N_89 N_155 200k
RR84 N_155 N_89 200k
RR85 N_89 N_86 200k
RR86 N_86 N_89 200k
RR87 N_231 N_86 200k
RR88 N_112 N_86 200k
RR89 N_86 N_112 200k
RR90 N_77 N_112 200k
RR91 N_88 N_84 1MEG
RR92 N_88 V12 100k
RR93 V12 N_83 100k
RR94 0 N_130 10k
RR95 N_122 V12 100
RR96 0 N_144 10k
RR97 N_60 N_128 10k
RR98 N_60 N_125 2.2k
RR99 N_132 N_131 100k
RTM3_a N_154 N_151 500K(B)
RTM3_b N_151 N_151 500K(B)
RTM4_a V12 N_114 50K(B)
RTM4_b N_114 V533 50K(B)
RTM5_a N_157 N_625 5K(B)
RTM5_b N_625 N_625 5K(B)
RVR2_a 0 N_102 50K(B)
RVR2_b N_102 V533 50K(B)
RVR3_a N_142 N_154 50K(A)
RVR3_b N_154 V12 50K(A)
RVR4_a 0 N_26 50K(B)
RVR4_b N_26 N_27 50K(B)
RVR4_c N_160 N_152 50K(B)
RVR4_d N_152 N_161 50K(B)
RVR5_a N_49 N_153 50K(A)
RVR5_b N_153 N_53 50K(A)
RVR6_a 0 0 1M(A)
RVR6_b 0 0 1M(A)
RVR6_c N_156 N_52 1M(A)
RVR6_d N_52 N_52 1M(A)
RVR7_a 0 N_35 50K(B)
RVR7_b N_35 N_150 50K(B)
RVR8_a 0 N_158 50K(A)
RVR8_b N_158 N_32 50K(A)
* elements: R=206 C=63 D=24 Q=39 J=2 other=270
